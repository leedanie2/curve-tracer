* 12_bare_loop_cin.cir -- bare loop (C1 empty) with a stray C_in at IN-,
* held at a DC level, as on the bench (MVP card steps 8-9, 2026-11-03).
*
* Topology is sim 10/11's (feedback after R_sense, B-E clamp, Q2 limiter),
* which is sim 08 plus the parts the board has. Added for the board as built:
* the PTC and the 1 ohm range-1 shunt in series after R_iso, D3 (SMAJ12A) as
* a capacitor on DUT_D, the 400k Kelvin divider, and the 10x scope probe on
* TP3 (emitter). R_f is the board's 23.2k. Slew is the OPA2197's 20 V/us.
*
* Steps: cin (stray at IN-), lcase (load across D-S), cd3 (D3 capacitance,
* not in any datasheet on hand, bracketed), vds (held level at FB_SENSE).
* The DAC steps from 0 at 2 us, as the firmware's hold does. A 5 mV, 0.2 us
* kick at 150 us re-excites a loop that settled after the step.
* Parse: python3 host/parse_osc.py sim/12_bare_loop_cin.raw

XU1 inp inm vcc 0 oa level2 Avol=1Meg GBW=10Meg Slew=20Meg Ilimit=65m Rail=0 Vos=0 En=0 Enk=0 In=0 Ink=0 Rin=500Meg
V2 inp 0 PWL(0 0 2u 0 2.1u {vds/3.32} 150u {vds/3.32} 150.01u {vds/3.32+0.0015} 150.2u {vds/3.32+0.0015} 150.21u {vds/3.32})
RG inm 0 10k
Rf fb inm 23.2k
Cin inm 0 {cin}
V1 vcc 0 15
Rbase base oa 330
XQ1 vcc base e BD139
D1 e base 1N4148
Q2 base e fb 0 2N3904
Rsense e fb 10
Cprobe e 0 12p
Rprobe e 0 10Meg
Riso fb load 22
Rptc load ptcout 8.4
Rsh ptcout dut 1
Cd3 dut 0 {cd3}
Rkel dut 0 400k
RL dut 0 {RLv}
CL dut 0 {CLv}

.model D D
.lib C:\users\crossover\AppData\Local\LTspice\lib\cmp\standard.dio
.model NPN NPN
.model PNP PNP
.lib C:\users\crossover\AppData\Local\LTspice\lib\cmp\standard.bjt
.include models/BD139.LIB
.lib UniversalOpAmp2.lib

.param vds=6
.step param cin list 0 5p 9p 15p 20p 30p
.step param lcase list 1 2
.step param cd3 list 0.5n 1.2n 2.2n
.param RLv=table(lcase,1,1e9,2,200)
.param CLv=table(lcase,1,1f,2,100n)
.tran 0 300u 0 5n
.save V(e) V(dut) V(oa) I(Rsh)
.end
