* 16_cap_only_opa197.cir -- does 100 nF alone across D-S, no resistor, keep the
* loop quiet from the DAC floor up? For MVP card session 3 (2026-11-09). If it
* does, the stabiliser carries no DC current and the host needs no R_p
* subtraction. TI's model, C1 empty, D3 1.2 nF, otherwise sim 15's circuit.
*
* With no resistor, Q1 carries only the feedback network and Kelvin divider:
* ~6 uA at the floor, r_e ~4 kohm. That is the hardest bias for the loop.
*
* Like sim 15 it starts from zero (uic): LTspice finds no operating point for
* TI's model here either (Gmin and source stepping fail, as in sim 14b). The
* DAC steps 0 -> level at 2 us, then by one sweep step (15 mV at the node) up
* at 30 us and back down at 50 us. Those two steps are the excitation that
* counts; the down-step is the one where the follower turns off.
*
* Three runs at the floor (k), the hardest bias:
*   1  100 nF at J6
*   2  the session-3 fixture: 100 nF on a breadboard ~5 cm away, behind
*      100 nH and 0.1 ohm of wire (D and S leads together)
*   3  open load: the reference that should ring
* 1 V and 6 V are 16b_cap_only_levels_opa197.cir. TI's model collapses its
* timestep once a run goes quiet, so those runs end at 25 us and use the
* start-up step alone.
* vds is referred to FB_SENSE; with no DC load the node sits at the same level.
* Parse: python3 host/parse_osc.py sim/16_cap_only_opa197.raw --ring 30.2e-6 49e-6
*        python3 host/parse_osc.py sim/16_cap_only_opa197.raw --ring 50.2e-6 69e-6
*        python3 host/parse_osc.py sim/16_cap_only_opa197.raw --residual 20e-6 29e-6
* The model is not committed (TI copyright); fetch it as sim/README.md says.

XU1 inp inm vcc 0 oa OPAx197
V2 inp 0 PWL(0 0 2u 0 2.1u {vds/3.32} 30u {vds/3.32} 30.05u {(vds+0.015)/3.32} 50u {(vds+0.015)/3.32} 50.05u {vds/3.32})
RG inm 0 10k
Rf fb inm 23.2k
Cin inm 0 {cin}
C1 fb inm {cf}
V1 vcc 0 15
Rbase base oa 330
XQ1 vcc base e BD139
D1 e base 1N4148
Q2 base e fb 0 2N3904
Rsense e fb 10
Cprobe e 0 12p
Rprobe e 0 10Meg
Riso fb load 22
Rptc load ptcout 8.4
Rsh ptcout dut 1
Cd3 dut 0 {cd3}
Rkel dut 0 400k
* the stabiliser: at J6 (Lw ~0) or behind the fixture's wires
Lw dut bb {Lwv} Rser={Rwv}
CL bb 0 {CLv}

.model D D
.lib C:\users\crossover\AppData\Local\LTspice\lib\cmp\standard.dio
.model NPN NPN
.model PNP PNP
.lib C:\users\crossover\AppData\Local\LTspice\lib\cmp\standard.bjt
.include models/BD139.LIB
.include models/OPAx197.LIB

.param cin=0
.param cf=0
.param cd3=1.2n
.step param k list 1 2 3
.param vds=0.205
.param Lwv=table(k,1,1p,2,100n,3,1p)
.param Rwv=table(k,1,1m,2,0.1,3,1m)
.param CLv=table(k,1,100n,2,100n,3,1f)
.tran 0 70u 0 5n uic
.save V(e) V(dut) V(oa) I(Rsh)
.end
